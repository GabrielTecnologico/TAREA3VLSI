ADE simulation setup
Run mode: Single Run, Sweeps and Corners
Tests:
  tarea_3_Flipflop_tb_1: tarea_3/Flipflop_tb/schematic, simulator spectre
    Variables: D = {Inclusion List}4.905n{Inclusion List}{From/To}Linear:4.905n:0.25p:4.909n{From/To}
    Outputs: fallingData; fallingCLK; /IN; Tsu; Th; risingData; risingQ; Tccq; Tcdq; plot; sadad

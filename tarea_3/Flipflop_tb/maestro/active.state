ADE simulation setup
Test tarea_3_Flipflop_tb_1: tarea_3/Flipflop_tb/schematic, simulator spectre
  Models: /mnt/vol_NFS_cadencedata/PDKS/XFAB_HOME/xh018/cadence/v9_0/spectre/v9_0_2/lpmos/config.scs[default], /mnt/vol_NFS_cadencedata/PDKS/XFAB_HOME/xh018/cadence/v9_0/spectre/v9_0_2/lpmos/param.scs[3s], /mnt/vol_NFS_cadencedata/PDKS/XFAB_HOME/xh018/cadence/v9_0/spectre/v9_0_2/lpmos/bip.scs[tm], /mnt/vol_NFS_cadencedata/PDKS/XFAB_HOME/xh018/cadence/v9_0/spectre/v9_0_2/lpmos/cap.scs[tm], /mnt/vol_NFS_cadencedata/PDKS/XFAB_HOME/xh018/cadence/v9_0/spectre/v9_0_2/lpmos/dio.scs[tm], /mnt/vol_NFS_cadencedata/PDKS/XFAB_HOME/xh018/cadence/v9_0/spectre/v9_0_2/lpmos/mos.scs[tm], /mnt/vol_NFS_cadencedata/PDKS/XFAB_HOME/xh018/cadence/v9_0/spectre/v9_0_2/lpmos/photo.scs[tm], /mnt/vol_NFS_cadencedata/PDKS/XFAB_HOME/xh018/cadence/v9_0/spectre/v9_0_2/lpmos/res.scs[tm]
  Variables: D = 4.905n
  Temperature: 27
  Analysis tran: stop=70n errpreset=conservative
  Output fallingData = cross(VT("/IN") 0.9 2 "falling" nil nil nil) (unticked)
  Output risingData = cross(VT("/IN") 0.9 3 "rising" nil nil nil) (unticked)
  Output fallingCLK = cross(VT("/CLK") 0.9 4 "falling" nil nil nil) (unticked)
  Output risingQ = cross(VT("/Q") 0.9 2 "rising" nil nil nil) (unticked)
  Output Tsu = (fallingCLK - fallingData)
  Output Th = (risingData - fallingCLK)
  Output Tccq = (risingQ - fallingCLK)
  Output Tcdq = (risingQ - fallingData)
  Output sadad = waveVsWave(?x VT("/CLK") ?y VT("/Q")) (unticked)
  Output plot = waveVsWave(?x VT("/CLK") ?y VT("/Q")) (unticked)
  Signals: /CLK, /IN, /Q
Run mode: Single Run, Sweeps and Corners
Setup values for test tarea_3_Flipflop_tb_1: D = {Inclusion List}4.905n{Inclusion List}{From/To}Linear:4.905n:0.25p:4.909n{From/To}
